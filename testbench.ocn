simulator( 'spectre )
design( "/home/hoangtrang/simulation/testbench/spectre/schematic/netlist/netlist" )
resultsDir( "/home/hoangtrang/simulation/testbench/spectre/schematic/netlist/results" )
modelFile(
    '("/home/hoangtrang/Thu_vien_PDK/PDK_CRN65LP_v1.7a_Official_IC61_20120914_all/PDK_CRN65LP_v1.7a_Official_IC61_20120914/tsmcN65/../models/spectre/toplevel.scs" "tt_lib")
)
analysis('tran ?stop "300n"  )
desVar(	  "m_comp" 10	)
desVar(	  "m_inv" 10	)
desVar(	  "m_nand2" 10	)
desVar(	  "m_nand3" 10	)
desVar(	  "m_nand4" 10	)
desVar(	  "m_nor2" 10	)
desVar(	  "m_nor3" 10	)
desVar(   "VP" 1.2 )

converge( 'ic "/I0/Q" "0" )
converge( 'ic "/I1/Q" "0" )
converge( 'ic "/I2/Q" "0" )
converge( 'ic "/I3/Q" "0" )
converge( 'ic "/I4/Q" "0" )
converge( 'ic "/I5/Q" "0" )
converge( 'ic "/I6/Q" "0" )
converge( 'ic "/I7/Q" "0" )
converge( 'ic "/I8/Q" "0" )
converge( 'ic "/I9/Q" "0" )
converge( 'ic "/I10/Q" "0" )
converge( 'ic "/I11/Q" "0" )
converge( 'ic "/I12/Q" "0" )
converge( 'ic "/I13/Q" "0" )
converge( 'ic "/I14/Q" "0" )
converge( 'ic "/I15/Q" "0" )
converge( 'ic "/I16/Q" "0" )
converge( 'ic "/I17/Q" "0" )
converge( 'ic "/I18/Q" "0" )
converge( 'ic "/I19/Q" "0" )
converge( 'ic "/I20/Q" "0" )
converge( 'ic "/I21/Q" "0" )
converge( 'ic "/I22/Q" "0" )
converge( 'ic "/I23/Q" "0" )
converge( 'ic "/I24/Q" "0" )
converge( 'ic "/I25/Q" "0" )
converge( 'ic "/I26/Q" "0" )
converge( 'ic "/I27/Q" "0" )
converge( 'ic "/I28/Q" "0" )
converge( 'ic "/I29/Q" "0" )
converge( 'ic "/I30/Q" "0" )
converge( 'ic "/I31/Q" "0" )
converge( 'ic "/I32/Q" "0" )
converge( 'ic "/I33/Q" "0" )
converge( 'ic "/I34/Q" "0" )
converge( 'ic "/I35/Q" "0" )
converge( 'ic "/I36/Q" "0" )
converge( 'ic "/I37/Q" "0" )
converge( 'ic "/I38/Q" "0" )
converge( 'ic "/I39/Q" "0" )
converge( 'ic "/I40/Q" "0" )
converge( 'ic "/I41/Q" "0" )
converge( 'ic "/I42/Q" "0" )
converge( 'ic "/I43/Q" "0" )
converge( 'ic "/I44/Q" "0" )
converge( 'ic "/I45/Q" "0" )
converge( 'ic "/I46/Q" "0" )
converge( 'ic "/I47/Q" "0" )
converge( 'ic "/I48/Q" "0" )
converge( 'ic "/I49/Q" "0" )
converge( 'ic "/I50/Q" "0" )
converge( 'ic "/I51/Q" "0" )
converge( 'ic "/I52/Q" "0" )
converge( 'ic "/I53/Q" "0" )
converge( 'ic "/I54/Q" "0" )
converge( 'ic "/I55/Q" "0" )
converge( 'ic "/I56/Q" "0" )
converge( 'ic "/I57/Q" "0" )
converge( 'ic "/I58/Q" "0" )
converge( 'ic "/I59/Q" "0" )
converge( 'ic "/I60/Q" "0" )
converge( 'ic "/I61/Q" "0" )
converge( 'ic "/I62/Q" "0" )
converge( 'ic "/I63/Q" "0" )

envOption(
	'analysisOrder  list("pz" "dcmatch" "stb" "tran" "envlp" "ac" "dc" "lf" "noise" "xf" "sp" "pss" "pac" "pstb" "pnoise" "pxf" "psp" "qpss" "qpac" "qpnoise" "qpxf" "qpsp" "hb" "hbac" "hbnoise" "sens" "acmatch")
)
temp( 27 )
save( 'i "VSP:p" )
run()
selectResult( 'tran )
val_va_out = value(VT( "/VA_OUT" ) 105n)
delay_ns = delay(?wf1 VT("/REN"), ?value1 0.6, ?edge1 "rising", ?nth1 2, ?td1 0, ?wf2 VT("/VA_OUT"), ?value2 0.24, ?edge2 "either", ?nth2 1,  ?td2 nil , ?stop 0.5, ?multiple nil)
power_w = average(i( "VSP:p"))*average(v( "/VDD" ))
out1 = outfile( "/home/hoangtrang/simulation/testbench/spectre/schematic/netlist/val_va_out.txt" "a" )
out2 = outfile( "/home/hoangtrang/simulation/testbench/spectre/schematic/netlist/delay_ns.txt" "a" )
out3 = outfile( "/home/hoangtrang/simulation/testbench/spectre/schematic/netlist/power_w.txt" "a" )
ocnPrint( ?output out1 val_va_out )
ocnPrint( ?output out2 delay_ns )
ocnPrint( ?output out3 power_w )
close(out1)
close(out2)
close(out3)
;ocnPrint( ?output "/home/hoangtrang/simulation/testbench/spectre/schematic/netlist/power_w.txt" power_w )
;plot(getData( "/VA_OUT" ) getData( "/VOUT<0>" ) getData( "/VOUT<1>" ) getData( "/VOUT<2>" ) getData( "/VOUT<3>" ) getData( "/CLK" ) getData( "/REN" ) getData( "/RWL0<63>" ) getData( "/RWL0<0>" ) getData( "/I63/Q") )
